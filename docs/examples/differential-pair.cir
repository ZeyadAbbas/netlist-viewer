.SUBCKT DIFFPAIR VINP VINN VOUT
VCCSRC VCC 0 DC 12
Q1 C1 VINP E NPN
Q2 VOUT VINN E NPN
RC1 VCC C1 4.7k
RC2 VCC VOUT 4.7k
ITAIL E 0 DC 1m
RLOAD VOUT 0 10k
.ENDS

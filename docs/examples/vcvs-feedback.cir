.SUBCKT VCVS_FEEDBACK VIN VOUT
VSIG VIN 0 SIN(0 100m 1k)
RIN VIN NINV 10k
RFB VOUT NINV 100k
RG NINV 0 10k
EAMP DRIVE 0 VIN NINV 100
ROUT DRIVE VOUT 47
CCOMP VOUT NINV 22p
RLOAD VOUT 0 10k
CLOAD VOUT 0 100p
.ENDS
